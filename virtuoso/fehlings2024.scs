simulator lang=spectre

ahdl_include "../heracles.va"

subckt fecap (te be)

parameters area = 625e-12
+          t_fe = 9.83e-9
+          t_int = 1.5e-9
+          eps_fe = 70
+          eps_int = 90
+          w_b = 1.05
+          d_e = 7.5e-9
+          e_off = 2e7
+          p_s = 27e-2
+          n_depl = 1.05e28
+          eps_depl = 3.6
+          q_fix_depl_u = -9.8e-2
+          q_fix_depl_d = 9.8e-2
+          m_eff_fe = 0.4
+          m_eff_int = 1
+          phi_b_fe = 2
+          phi_b_int = 0.65
+          mu_fe = 15e-4
+          n_c_fe = 1e24
+          phi_tr_fe = 0.68

C1 (te be) heracles area = area
+          t_fe = t_fe
+          t_int = t_int
+          eps_fe = eps_fe
+          eps_int = eps_int
+          w_b = w_b
+          d_e = d_e
+          e_off = e_off
+          p_s = p_s
+          n_depl = n_depl
+          eps_depl = eps_depl
+          q_fix_depl_u = q_fix_depl_u
+          q_fix_depl_d = q_fix_depl_d
+          m_eff_fe = m_eff_fe
+          m_eff_int = m_eff_int
+          phi_b_fe = phi_b_fe
+          phi_b_int = phi_b_int
+          mu_fe = mu_fe
+          n_c_fe = n_c_fe
+          phi_tr_fe = phi_tr_fe

ends fecap

parameters area_mc=0 t_fe_mc=0 t_int_mc=0 d_e_mc=0 p_s_mc=0 n_depl_mc=0

statistics{
    process{ // Variation per MC run
	vary t_int_mc dist=gauss std=2.2e-10
	vary p_s_mc dist=gauss std=0.027
	vary n_depl_mc dist=gauss std=0.265e28
   	truncate tr=3
    }
    mismatch{ // Variation per instance
	vary area_mc dist=gauss std=1e-12
	truncate tr=3
    }
}
